Netlist without end card
* expect-anywhere: missing-end
V1 in 0 DC 1
R1 in out 1k
R2 out 0 2k
.tran 1n 10n
